`include "pl_regs.vh" //automatically created and added by fwk with conf variables such a C_VERSION ...

/* default values of defined variables */
`ifndef C_ID
`define C_ID 0xE1C00100
`endif
`ifndef C_VERSION
`define C_VERSION 0x00000000
`endif
`ifndef C_PRJ_ID
`define C_PRJ_ID 0xE1C00010
`endif
`ifndef C_PRJ_VERSION
`define C_PRJ_VERSION 0x00000000
`endif
`ifndef C_PRJ_TIMESTAMP
`define C_PRJ_TIMESTAMP 0x00000000
`endif
`ifndef C_PRJ_SHASUM
`define C_PRJ_SHASUM 0x00000000
`endif

/*
  module a address space
*/
addrmap pl_regs {
  name = "Example module for the example application";
  desyrdl_interface = "AXI4L";



reg {
    desc="GPIO Inputs";
    default sw = rw;
    default hw = w;
    field {} data[4];
  } gpio_in @0x0;

reg {
    desc="GPIO Outputs";
    default sw = rw;
    default hw = r;
    field {} data[4];
  } gpio_out @0x4;

reg {
    desc="ADC Testmode bit0=enb, bit1=rst";
    default sw = rw;
    default hw = r;
    field {} data[2];
  } adc_testmode @0x8;


reg {
    desc="FP Leds";
    default sw = rw;
    default hw = r;
    field {} data[4];
  } fp_leds @0x14;
  
reg {
    desc="FPGA Version";
    default sw = rw;
    default hw = w;
    field {} data[32];
  } fpgaver @0x1C;  

reg {
    desc="SA Divide value (num ADC samples to average for SA data)";
    default sw = rw;
    default hw = r;
    field {} data[32] = 38000;
  } sa_divide @0x20; 

reg {
    desc="SA Interrupt Enable";
    default sw = rw;
    default hw = r;
    field {} data[1];
  } sa_irqenb @0x24; 

reg {
    desc="FA Divide value (num ADC samples to average for FA data)";
    default sw = rw;
    default hw = r;
    field {} data[32] = 38;
  } fa_divide @0x28; 
  
 reg {
    desc="ADC clock source (0=internal, 1=EVR)";
    default sw = rw;
    default hw = r;
    field {} data[1] = 1;  //set to EVR 
  } mach_clk_sel @0x2C;  
  
 reg {
    desc="Fan Speed";
    default sw = rw;
    default hw = r;
    field {} data[6];
  } fan_setspeed @0x30; 

 reg {
    desc="Fan Tach";
    default sw = r;
    default hw = w;
    field {} data[16];
  } fan_tachcnt @0x34; 

 reg {
    desc="Fan Status";
    default sw = r;
    default hw = w;
    field {} data[8];
  } fan_status @0x38; 

 reg {
    desc="SA Trigger Number";
    default sw = r;
    default hw = w;
    field {} data[32];
  } sa_trignum @0x40; 

 reg {
    desc="Kx";
    default sw = rw;
    default hw = r;
    field {} data[32] = 10000000;  // 10e6 nm 
  } kx @0x44; 

 reg {
    desc="Ky";
    default sw = rw;
    default hw = r;
    field {} data[32] = 10000000;  // 10e6 nm
  } ky @0x48; 

 reg {
    desc="Machine Clock Divide.  Not used (divide is fixed in firmware)";
    default sw = rw;
    default hw = r;
    field {} data[8] = 132;   // 100MHz / 2 / 378.545KHz
  } machclk_divide @0x4C;

reg {
    desc="ChA Offset";
    default sw = rw;
    default hw = r;
    field {} data[32];
  } cha_offset @0x50;
 
reg {
    desc="ChB Offset";
    default sw = rw;
    default hw = r;
    field {} data[32];
  } chb_offset @0x54;
 
reg {
    desc="ChC Offset";
    default sw = rw;
    default hw = r;
    field {} data[32];
  } chc_offset @0x58;
 
reg {
    desc="ChD Offset";
    default sw = rw;
    default hw = r;
    field {} data[32];
  } chd_offset @0x5C;
 
reg {
    desc="ChA Gain";
    default sw = rw;
    default hw = r;
    field {} data[16] = 32767;
  } cha_gain @0x60;
 
reg {
    desc="ChB Gain";
    default sw = rw;
    default hw = r;
    field {} data[16] = 32767;
  } chb_gain @0x64;
 
 reg {
    desc="ChC Gain";
    default sw = rw;
    default hw = r;
    field {} data[16] = 32767;
  } chc_gain @0x68;
 
 reg {
    desc="ChD Gain";
    default sw = rw;
    default hw = r;
    field {} data[16] = 32767;
  } chd_gain @0x6C;
 

reg {
    desc="AFE Gain Select";
    default sw = rw;
    default hw = r;
    default swacc=true;
    default swmod=true;
    field {} data[32];
  } afe_cntrl @0x70;
  
  
reg {
    desc="AFE DB Gain Select";
    default sw = rw;
    default hw = r;
    field {} data[8];
  } afe_db_gain @0x74;
    
  
reg {
    desc="GTX Reset";
    default sw = rw;
    default hw = r;
    field {} data[8];
  } gtx_reset @0x7C;


reg {
    desc="Bias DAC";
    default sw = rw;
    default hw = r;
    default swacc=true;
    default swmod=true;
    field {} data[32];
  } bias_dac @0x80;

reg {
    desc="XPos Offset";
    default sw = rw;
    default hw = r;
    field {} data[32];
  } xpos_offset @0x88;

reg {
    desc="YPos Offset";
    default sw = rw;
    default hw = r;
    field {} data[32];
  } ypos_offset @0x8C;

reg {
    desc="ADC raw CHA";
    default sw = r;
    default hw = w;
    field {} data[32];
  } adc_raw_cha @0x90; 

reg {
    desc="ADC raw CHB";
    default sw = r;
    default hw = w;
    field {} data[32];
  } adc_raw_chb @0x94; 

reg {
    desc="ADC raw CHC";
    default sw = r;
    default hw = w;
    field {} data[32];
  } adc_raw_chc @0x98; 

reg {
    desc="ADC raw CHD";
    default sw = r;
    default hw = w;
    field {} data[32];
  } adc_raw_chd @0x9C; 

reg {
    desc="ADC raw CHE";
    default sw = r;
    default hw = w;
    field {} data[32];
  } adc_raw_che @0xA0; 

reg {
    desc="ADC raw CHF";
    default sw = r;
    default hw = w;
    field {} data[32];
  } adc_raw_chf @0xA4; 

reg {
    desc="ADC raw CHG";
    default sw = r;
    default hw = w;
    field {} data[32];
  } adc_raw_chg @0xA8; 

reg {
    desc="ADC raw CHH";
    default sw = r;
    default hw = w;
    field {} data[32];
  } adc_raw_chh @0xAC; 

reg {
    desc="SA data chA";
    default sw = r;
    default hw = w;
    field {} data[32];
  } sa_cha @0xB0; 

reg {
    desc="SA data chB";
    default sw = r;
    default hw = w;
    field {} data[32];
  } sa_chb @0xB4; 

reg {
    desc="SA data chC";
    default sw = r;
    default hw = w;
    field {} data[32];
  } sa_chc @0xB8; 
  
reg {
    desc="SA data chD";
    default sw = r;
    default hw = w;
    field {} data[32];
  } sa_chd @0xBC;  
  
reg {
    desc="SA data sum";
    default sw = r;
    default hw = w;
    field {} data[32];
  } sa_sum @0xC0;  
  
reg {
    desc="SA data Xpos";
    default sw = r;
    default hw = w;
    field {} data[32];
  } sa_xpos @0xC4;  
  
reg {
    desc="SA data YPos";
    default sw = r;
    default hw = w;
    field {} data[32];
  } sa_ypos @0xC8;      




/* EVR Registers */
 reg {
    desc="Timestamp (s)";
    default sw = r;
    default hw = w;
    field {} data[32];
  } ts_s @0xD0;

reg {
    desc="Timestamp (ns)";
    default sw = r;
    default hw = w;
    field {} data[32];
  } ts_ns @0xD4;
  
reg {
    desc="EVR Trigger Timestamp (s)";
    default sw = r;
    default hw = w;
    field {} data[32];
  } ts_s_trig @0xD8;

reg {
    desc="EVR Trigger Timestamp (ns)";
    default sw = r;
    default hw = w;
    field {} data[32];
  } ts_ns_trig @0xDC;  

reg {
    desc="EVR Trigger Delay";
    default sw = rw;
    default hw = r;
    field {} data[32];
  } evr_trig_delay @0xE0; 
  
reg {
    desc="EVR Trigger Event Number";
    default sw = rw;
    default hw = r;
    field {} data[8];
  } evr_trig_eventno @0xE4;  

 
reg {
    desc="DDS frequency";
    default sw = rw;
    default hw = r;
    field {} data[32];
  } dds_freq @0xF0;  
 
reg {
    desc="POS Sim / Real select (0=sim (use DDS), 1=real)";
    default sw = rw;
    default hw = r;
    field {} data[1];
  } pos_sim_real_sel @0xF4;  


/* Feedback DAC  */
reg {
    desc="Feedback DAC";
    default sw = rw;
    default hw = r;
    default swacc=true;
    default swmod=true;
    field {} data[32];
  } fdbk_dac @0x120; 

reg {
    desc="Feedback DAC LDAC";
    default sw = rw;
    default hw = r;
    field {} data[1];
  } fdbk_dac_ldac @0x124; 

 reg {
    desc="Feedback DAC Opmode (0=arm, 1=adc)";
    default sw = rw;
    default hw = r;
    field {} data[1];
  } fdbk_dac_opmode @0x128; 


/* Heat Pump DAC (for temperature stability)  */
reg {
    desc="Heat Pump DAC";
    default sw = rw;
    default hw = r;
    default swacc=true;
    default swmod=true;
    field {} data[32];
  } heat_dac @0x130; 

 reg {
    desc="Heat Pump Dac LDAC)";
    default sw = rw;
    default hw = r;
    field {} data[1];
  } heat_dac_ldac @0x134; 


reg {
    desc="Thermistor  LTC2986";
    default sw = rw;
    default hw = rw;
    default swacc=true;
    default swmod=true;
    field {} data[32];
  } thermistor @0x140; 


reg {
    desc="Temperature Sensor 0";
    default sw = rw;
    default hw = w;
    field {} data[16];
  } temp0 @0x150; 

reg {
    desc="Temperature Sensor 1";
    default sw = rw;
    default hw = w;
    field {} data[16];
  } temp1 @0x154; 

reg {
    desc="Input Voltage";
    default sw = rw;
    default hw = w;
    field {} data[16];
  } vin @0x158; 

reg {
    desc="Input Current";
    default sw = rw;
    default hw = w;
    field {} data[16];
  } iin @0x15C; 




/* FA FIFO Readout Registers */

reg {
    desc="FA Soft Trig";
    default sw = rw;
    default hw = r;
    field {} data[1];
  } fa_softtrig @0x200;

reg {
    desc="FA Trig Status";
    default sw = r;
    default hw = w;
    field {} data[2];
  } fa_trigstat @0x204;

reg {
    desc="FA Trig Clear - Stop Acq.";
    default sw = rw;
    default hw = r;
    field {} data[1];
  } fa_trigclear @0x208;




reg {
    desc="FA FIFO Readout Enable";
    default sw = rw;
    default hw = r;
    default swmod=true; 
    field {} data[1];
  } fafifo_streamenb @0x210;
     
reg {
    desc="FA FIFO Reset";
    default sw = rw;
    default hw = r;
    field {} data[1];
  } fafifo_reset @0x214;
   
reg {
    desc="FA FIFO Data Out";
    default sw = r;
    default hw = w;
    default swacc=true;   
    field {} data[32];
  } fafifo_data @0x218;
   
reg {
    desc="FA FIFO Word Count";
    default sw = r;
    default hw = w;
    field {} data[32];
  } fafifo_rdcnt @0x21C;
   
   
   
/* FA Fiber Optic Received FIFO Readout Registers */
reg {
    desc="FA RCVD FIFO Readout Enable";
    default sw = rw;
    default hw = r;
    default swmod=true; 
    field {} data[1];
  } fafifo_rcvd_streamenb @0x220;
     
reg {
    desc="FA RCVD FIFO Reset";
    default sw = rw;
    default hw = r;
    field {} data[1];
  } fafifo_rcvd_reset @0x224;
   
reg {
    desc="FA FIFO Data Out";
    default sw = r;
    default hw = w;
    default swacc=true;   
    field {} data[32];
  } fafifo_rcvd_data @0x228;
   
reg {
    desc="FA FIFO Word Count";
    default sw = r;
    default hw = w;
    field {} data[32];
  } fafifo_rcvd_rdcnt @0x22C;





  reg {
    desc = "Module Identification Number";
    default sw = r;
    default hw = r;
    field {} data[32] = `C_ID;
  } ID @0x400;

  reg {
    desc = "Module Version Number";
    default sw = r;
    default hw = r;
    field {} changes [8] =  `C_VERSION & 0x000000FF;
    field {} patch [8]   = (`C_VERSION & 0x0000FF00) >> 8;
    field {} minor [8]   = (`C_VERSION & 0x00FF0000) >> 16;
    field {} major [8]   = (`C_VERSION & 0xFF000000) >> 24;
  } VERSION @0x404;

  reg {
    desc="Project Identification Number";
    default sw = r;
    default hw = r;
    field {} data[32] = `C_PRJ_ID;
  } PRJ_ID @0x408;

  reg {
    desc="Project Version Number";
    default sw = r;
    default hw = r;
    field {} changes [8] =  `C_PRJ_VERSION & 0x000000FF;
    field {} patch [8]   = (`C_PRJ_VERSION & 0x0000FF00) >> 8;
    field {} minor [8]   = (`C_PRJ_VERSION & 0x00FF0000) >> 16;
    field {} major [8]   = (`C_PRJ_VERSION & 0xFF000000) >> 24;
  } PRJ_VERSION @0x40C;

  reg {
    desc="Project Repository check sum.";
    default sw = r;
    default hw = r;
      field {} data[32] = `C_PRJ_SHASUM;
  } PRJ_SHASUM @0x410;

  reg {
    desc="Project compilation timestamp";
    default sw = r;
    default hw = r;
    field {} data[32] = `C_PRJ_TIMESTAMP;
  } PRJ_TIMESTAMP @0x414;







};
